* set gnd and power
Vgnd VGND 0 0
Vdd VPWR VGND 1.8

* Increment high
Rinc VPWR INC 0.1

* create pulse
Va0 A0 VGND pulse(0 1.8 300p 10p 10p 300p 600p)
Va1 A1 VGND pulse(0 1.8 1p 10p 10p 1n 2n)
Va2 A2 VGND pulse(0 1.8 1p 10p 10p 3n 6n)
.tran 10e-12 12e-09 0e-00

.control
run
set color0 = white
set color1 = black
plot A0 A1+0.2 A2+0.4 S0+0.6 S1+0.8 S2+1.0
plot i(Vdd)
.endc

.end
