NOR Simulation
* this file edited to remove everything not in tt lib
.lib "./sky130_fd_pr/models/sky130.lib.spice" tt

* instantiate the ha
Xha S C A B VPWR VGND VGND VPWR ha

.subckt ha S C A B NWELL VSUBS VGND VPWR
