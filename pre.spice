Incrementer Simulation
.include "pdk_lib.spice"

* instantiate the incrementer
Xinc INC A0 S0 A1 S1 A2 S2 VPWR VGND tt_um_flat
